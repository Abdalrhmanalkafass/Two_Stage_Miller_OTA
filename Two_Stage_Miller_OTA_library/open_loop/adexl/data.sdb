ADE simulation setup
Run mode: Single Run, Sweeps and Corners
Tests:
  lab9_iti:open_loop:1: lab9_iti/open_loop/schematic, simulator spectre
Global variables:
  cl = 5p
  vid = 0
  vidac = 1
  vincm = 0.6
  vincmac = 0
  w = 1u:5u:50u
