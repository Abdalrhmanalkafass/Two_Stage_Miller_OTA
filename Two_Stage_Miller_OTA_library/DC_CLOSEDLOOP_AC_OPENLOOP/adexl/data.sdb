ADE simulation setup
Run mode: Single Run, Sweeps and Corners
Tests:
  miniproject1:DC_CLOSEDLOOP_AC_OPENLOOP:1: miniproject1/DC_CLOSEDLOOP_AC_OPENLOOP/schematic, simulator spectre
    Outputs: A0; A0_db; BW; fu; GBW; gain_db
Global variables:
  vincm = 0.6
  vincm_ac = 1
  vind = 0
  vind_ac = 0
  vdc = 0.6
