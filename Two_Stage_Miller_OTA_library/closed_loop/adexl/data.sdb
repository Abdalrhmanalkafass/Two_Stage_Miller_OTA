ADE simulation setup
Run mode: Single Run, Sweeps and Corners
Tests:
  miniproject1:closed_loop:1: miniproject1/closed_loop/schematic, simulator spectre
    Outputs: A0; A0_db; BW; fu; GBW; vout; slew rate; rise time; A0cl; fucl; VF("/Vout")
